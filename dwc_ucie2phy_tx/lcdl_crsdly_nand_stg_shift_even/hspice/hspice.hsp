* "hspice" description for "dwc_ucie2phy_lcdl", "lcdl_crsdly_nand_stg_shift_even", "hspice"

simulator lang=hspice

.SUBCKT lcdl_crsdly_nand_stg_shift_even

.ENDS lcdl_crsdly_nand_stg_shift_even
